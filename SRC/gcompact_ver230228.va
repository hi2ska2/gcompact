// --------------------------------------------------------
// --------------------------------------------------------
// --------------------------------------------------------
// -------------------- GCOMPACT model --------------------
// --------------------------------------------------------
// --------------------------------------------------------
// --------------------------------------------------------

`include "constants.vams"
`include "disciplines.vams"
`include "common_def.include"

module gcompact (d, g, s, b);

	inout d, g, s, b;
	electrical d, g, s, b;
	electrical di, si;

	// N|P Type
	parameter real TYPE = `ntype;
	parameter integer DEVTYPE = `ntype from [0:1]; // MOSFET type

	// instance & model parameter
	parameter real       metal      = 4.30 from [0:inf); // Gate workfunction
	parameter real       Eg0    	= 1.16964 from [0:inf); // Bandgap of substrate at 300K
	parameter real       aff0	= 4.05 from [0:inf); // Electron affinity of substrate
	parameter real       NC0    	= 2.5094E+25 from [0:inf); // electron concentration in conduction band
	parameter real       ml    	= 0.9163 from [0:inf);
	parameter real	     Imin	= 1.0e-15 from [0:inf);

	// material default constant
	parameter real       epsrsi     = 11.7; // permittivity constant of substrate
	parameter real       epsrox     = 3.9; // permittivity constant of insulator

	// pre-calculated alphaeH parameter in paper
	parameter real       aa    	= 3.3661; // pre-calculated parameter aa
	parameter real       bb    	= 0.9; // pre-calculated parameter bb
	parameter real       alphad     = 0.5 from [0:inf); // pre-calculated parameter alphad

	// pre-calculated Density-gradient parameter
	parameter real       gamma   	= 3.6; // for silicon

	// mobility parameter
	parameter real       Un0    	= 1417.0E-4 from [0:inf);// low field electron mobility
	parameter real       Up0    	= 470.5E-4 from [0:inf); // low field mobility
	// *********************************************************************************
	// edit part
	parameter integer	GEOMOD  = 2 from [0:4]; // MOSFET Fin shape.
	parameter integer	QCEMOD  = 0 from [0:1]; // Quantum Confinement Effect mode
	parameter integer	SCEMOD  = 0 from [0:1]; // Short channel Effect mode

	parameter real	NSD     = 1.0e+26 from [0:inf); // [/m3] Source / Drain doping
	parameter real	Nbody   = 1.0e+22 from [0:inf); // [/m3] Channel doping
	parameter real	Nes_i   = 1.0e-24 from [0:inf);
	parameter real	Ned_i   = Nes_i from [0:inf);

	parameter real	LSD     = 5.0e-9 from [0:inf);
	parameter real	L       = 1000.0e-9 from [0:inf);
	parameter real	WFIN    = 36.0e-9 from [0:inf);
	parameter real	HFIN    = 9.0e-9 from [0:inf);
	parameter real	Tox     = 1.0e-9 from [0:inf);

	parameter real	R       = 0.0e-9 from [0:inf); // [m] Channel radius [GEOMOD = 3]
	parameter real	r       = 0.0e-9 from [0:inf); // [m] Rounded-corner radius [GEOMOD = 4]

	parameter real	alphaeL = 0.499001684232087 from [0:inf);
	parameter real	beta2   = 1.00049033689586 from [0:inf);
	parameter real	Cg      = 3.17199789621433E-09 from [0:inf);
	parameter real	offset  = -0.0000137768481862366 from (-inf:inf);

	parameter real	etaXL   = 0.0 from [0:inf);
	parameter real	etasL   = 0.0 from [0:inf);

	parameter real  mexp   	= 4.0 from [0:inf); 	 // Smoothing function factor for Vdsat
	parameter real	VE	= 0.18 from [0:inf);
	parameter real  vsat   	= 107.0E+3 from [0:inf); // saturation electron velocity in high e-field
	//parameter real vsatp	= 83.7E+3 from [0:inf); // saturation hole velocity in high e-field
	//parameter real vsatnexp	= 0.87 from [0:inf); // saturation electron velocity exponential term
	//parameter real vsatpexp	= 0.52 from [0:inf); // saturation hole velocity exponential term
	//parameter real beta0n	= 1.109 from [0:inf); // electron velocity beta0 term
	//parameter real beta0p	= 1.213 from [0:inf); // hole velocity beta0 term
	//parameter real beta0nexp	= 0.66 from [0:inf); // electron velocity beta0 exponontial term
	//parameter real beta0pexp	= 0.17 from [0:inf); // hole velocity beta0 exponential term
	// *********************************************************************************
	// parameter for SHORT CHANNEL EFFECT [SCEMOD==1] ref. BSIM-CMG
	parameter real	ETA0 = 1.0 from [0:inf); // DIBL coefficient
	parameter real	DSUB = 1.06 from [0:inf); // DIBL exponent coefficient
	parameter real	DVT0 = 1.0 from [0:inf); // SCE coefficient
	parameter real	DVT1 = 0.6 from (0:inf); // SCE exponent coefficient. After binning it should be within (0 : inf)
	parameter real 	DVT1SS = DVT1 from (0:inf);

	// fitting parameter for QUANTUM CONFINEMENT EFFECT [QCEMOD==1]
	parameter real      a1    = 2.8;
	parameter real      a2    = 0.85;
	parameter real      a3    = 1.43;
	parameter real      a4    = 0.8;
	parameter real      a5    = 0.2;
	parameter real      a6    = 0.45;
	parameter real      a7    = 1.65;
	parameter real      a8    = 0.82;
	parameter real      a9    = 0.4;
	parameter real      a10   = 0.35;
	parameter real      a11   = 0.8945;
	parameter real      a12   = 0.3215;

	// local parameter
	integer iter;
	real Temp;
	real devsign;
	real mt, mn, mh, aff, ni, Nc, Nv;
	real Eg, semi, deltaPHI, Ec_Ef, Vfb;
	real Vgs, Vgsi;
	real Vds, Vdsx, Vdsi, Vdisi;
	real Vbs;
	real Ids, IDS;
	real Vgsms, Vgsmseff;
	real Vssi, Vddi;
	real VTH0, VTH;
	real Em, Esat, EsatL, inv_mexp;
	real Leff, Weff, deltaL;
	real epssi, epsox, epsratio, Rox;
	real Cins, cins;
	real Vt;
	real MS, Vch;
	real Ach, Pch, rc;
	real Nd, Qdtd, Qd, qd;
	real Nes, Qes, Qestd, qes;
	real Ned, Qed, Qedtd, qed;
	real Qeseff;
	real qea, qbs;
	real alphaeH, alphae, dalphae;
	real alphaeH_s, dalphae_s, alphae_s;
	real alphaeH_d, dalphae_d, alphae_d;
	real Res, Jaco, update;
	real un0, up0;
	real coef;
	real A, Lambda, HFINeff, Lambdaeff, theta_Leff;
	real dVgs, VsL, Vsmin, y0, ymc, Z0, ZL, Psicmin;
	real tmp, T0, T1, T2, T3, T4, T5, T6, T7, T8, T9, T10;
	real Q0, U, X, Y, Z;
	real bn;
	real phin, phib, Vbi, phis, phist;
	real etas_s, detas_s, etaXs_s, detaXs_s;
	real etas_d, detas_d, etaXs_d, detaXs_d;
	real beta0;
	real Theta_SW, Theta_SCE, Theta_DIBL, Theta_DITS;
	real dvth_vtroll, dvth_dibl, dvth_all;
	real Rs, Rd;
	real Ldi, Vdsat, Vdsat2, Vdseff;

	analog begin
	// Type
	if ( TYPE == `ntype ) begin
		devsign = 1;
	end else begin
		devsign = -1;
	end
	// Temperature (K)
	Temp = `temp + `constCtoK;

	// parameter pre-calculation
	Vt    = `kB*Temp/`q;
	Eg    = Eg0 - (4.73e-4)*pow(Temp,2)/(Temp+636.0); // Bandgap
	aff   = aff0 + (4.73e-4)*pow(Temp,2)/(2.0*(Temp+636.0)); // electron affinity
	mt    = 0.1905*(Eg0/Eg);
	mn    = `m0*pow((pow((6.0*mt),2.0)*ml),`one_ov_3);
	mh    = `m0*pow(((0.443587+0.003609528*Temp+0.0001173515*pow(Temp,2)+1.263218e-6*pow(Temp,3)+3.025581e-9*pow(Temp,4))/(1.0+0.004683382*Temp+0.0002286895*pow(Temp,2)+7.469271e-7*pow(Temp,3)+1.727481e-9*pow(Temp,4))),`two_ov_3);
	Nc    = NC0*pow((mn/`m0)*(Temp/300.0),1.5);
	Nv    = NC0*pow((mh/`m0)*(Temp/300.0),1.5);
	ni    = $sqrt(Nc*Nv) * exp(-Eg/2.0/Vt);
	Ec_Ef = -Vt * ln(ni/Nc);
	semi  = aff + Ec_Ef;
	MS	= metal - semi;
	epssi = `eps0 * epsrsi;
	epsox = `eps0 * epsrox;
	epsratio = epssi / epsox;
	un0   = Un0;
	up0   = Up0;
	bn    = gamma * `hbar * `hbar / (12.0 *`q * mn);

	case (GEOMOD)
	0: begin // double gate
		Pch	= 2.0 * HFIN;
		Ach	= HFIN * WFIN;
		Cins	= Pch * epsox / Tox;
		A	= 0.0;
	end

	1: begin // triple gate
		Pch	= 2.0 * HFIN + WFIN;
		Ach	= HFIN * WFIN;
		Cins	= Pch * epsox / Tox;
		A	= 0.5;
	end

	2: begin // quadruple gate (square, rectangular)
		Pch	= 2.0 * (HFIN + WFIN);
		Ach	= HFIN * WFIN;
		Cins	= Cg; // calculated Cins from numerical result
		A	= 1.0;
	end

	3: begin // cylindrical gate
		Rox	= R + Tox;
		Pch	= 2.0 * `pi * R;
		Ach	= `pi * R * R;
		Cins	= 2.0 * `pi * epsox / ln(1.0 + Tox/R);
	end

	4: begin // rounded corner nanosheet
		Pch	= 2.0*`pi*R + 2.0*(HFIN-2.0*R) + 2.0*(WFIN-2.0*R);
		Ach	= `pi*pow(R,2) + HFIN*WFIN - 2.0*R*(HFIN+WFIN);
		Cins	= (5/2*epsox) / (ln(1.0 + (5.0*Tox) / (4.0*WFIN)))
			+ (2.5*epsox) / (ln(1.0 + (5.0*Tox) / (4.0*HFIN)))
			- (2.5*epsox) / (ln(1.0 + (5.0*Tox) / (4.0*(WFIN-2.0*r))))
			- (2.5*epsox) / (ln(1.0 + (5.0*Tox) / (4.0*(HFIN-2.0*r))));
	end
	endcase

	cins	= Cins / Pch; // average Cins : <Cins>s

	// effective channel length and width
	Leff	= L;
	Weff	= Pch;

	// Port voltage
	Vgs = V(g,s);
	Vds = V(d,s); Vdsx = sqrt(Vds * Vds + 0.01) - 0.1;
	Vbs = V(b,s);

	Rs = (LSD*1e2) / (`q*un0*1e4*NSD/1e6*Ach*1e4);
	Rd = (LSD*1e2) / (`q*un0*1e4*NSD/1e6*Ach*1e4);
	Vssi  = I(si,s) * Rs;
	Vddi  = I(d,di) * Rd;
	Vdisi = V(di,si);
	Vgsi  = V(g,si);
	Vdsi  = V(d,si);

	// Fitting equation considered Quantum confinement Effect
	Q0	= Pch * Pch / Ach * epssi * Vt;
	Y	= 2.0 - 16.0 * Ach / pow(Pch,2);
	Z	= Ach / Pch / 1e-9;
	X	= 1.0 + pow(10,(-1.5*$log10(Z/Y)+a11*$log10(gamma)+a12));
	U	= (0.1+gamma)/3.7;

	// Depletion charge
	Nd	= Nbody * Ach;
	Qd	= -`q * Nd;
	qd	= -`q * Nd / (Cins * Vt);
	qbs	= +`q * Nd / Cins;
	inv_mexp = 1.0 / mexp;

	// potential parameter
	phin	= 0.0; // non-uniform lateral doping
	phib	= Vt * ln(Nbody/ni);
	phist	= 0.4 + phib + phin;
	Vbi	= Vt * ln(NSD*Nbody/pow(ni,2));

	// characteristic length
	Lambda	= sqrt((epssi*Ach/Cins) * (1.0 + (Ach*Cins)/(2.0*epssi*Pch*Pch)));
	//if (GEOMOD == 3) begin
	//	Lambdaeff	= Lambda;
	//end else if (GEOMOD == 1 || GEOMOD == 2)begin // effective Lambda for GEOMOD==1||2
	//	HFINeff	= sqrt(epsratio/4.0*(1.0+WFIN/(2.0*epsratio*Tox))*HFIN*Tox);
	//	Lambdaeff	= A / sqrt(1.0/(epsratio/2.0*(1+TFIN/(4.0*epsratio*Tox))*TFIN*Tox)+1.0/(4.0*HFINeff));
	//end
	Lambdaeff = Lambda;

	Vgsms = Vgs - MS;

	// Effective gate voltage
	if (SCEMOD == 1) begin
		VsL	= Vgs - MS - (`q*Nbody/epssi)*pow(Lambdaeff,2);
		Z0	= Vbi - VsL;
		ZL	= Vbi - VsL + Vds;

		if (Z0<0.0 || ZL<0.0) begin
			dVgs = 0.0;
		end else begin
			dVgs = - (pow(Vds,2)*exp(-Leff/(2.0*Lambdaeff))) / ((exp(Leff/Lambdaeff)-exp(-Leff/Lambdaeff))*sqrt(Z0*ZL))
				+ 2.0 * sqrt(Z0*ZL) * sinh(Leff/(2.0*Lambdaeff)) / sinh(Leff/Lambdaeff);
		end
	end else begin
		dVgs = 0.0;
	end

	Vgsms = Vgsms + dVgs;

	// Coefficient for calculating charge
	coef = 2.0 * pow(Pch,2) * epssi * Vt * ni;

	// initial solution for calculation
	Nes = Nes_i;

	// Source side compact charge core model
	Vch = Vssi;

	for (iter = 1; iter <= 50; iter = iter + 1) begin

	if (QCEMOD == 0) begin

		alphaeH_s	= aa*pow((`q*Nes/Q0),-bb);
		alphae_s	= (alphaeL * alphaeH_s) / (alphaeL + alphaeH_s);
		dalphae_s	= -(((pow(alphaeL,2)*aa*bb*`q)/Q0)*pow(`q*Nes/Q0,(-bb-1))) / pow((alphaeL + aa*pow((`q*Nes/Q0),-bb)),2);

		Res		= Vgsms - Vch - `q*Nd/Cins - `q*Nes/Cins - Vt*ln((`q*Nes*Nes + 2.0*(1.0-alphae_s)*`q*Nes*Nd)/coef + beta2*Nes/(Ach*ni)) - offset;
		Jaco		= - `q/Cins - Vt*((2.0*`q*Nes + 2.0*(1.0 - alphae_s - dalphae_s*Nes)*`q*Nd)/coef + beta2/(Ach*ni))
					/ ((`q*Nes*Nes + 2.0*(1.0-alphae_s)*`q*Nes*Nd)/coef + beta2*Nes/(Ach*ni));

	end else if (QCEMOD == 1) begin

		alphae_s    = 1.0/(1.0/0.5 + pow((`q*Nes/Q0/X/Y),a2)/a1)*alphaeL/0.5;
		dalphae_s   = - 1.0/pow((1/0.5 + pow((`q*Nes/Q0/X/Y),a2)/a1),2) * a2/a1 * `q/(Q0*X*Y) * pow((`q*Nes/Q0/X/Y),(a2-1.0))*alphaeL/0.5 ;
		etaXs_s     = exp(ln(etaXL/etasL) + (pow((`q*Nes*a7/Z/Q0),a8))*pow(U,a10)/pow(Y,a9));
		detaXs_s    = pow(U,a10)/pow(Y,a9) * pow((`q*a7/Z/Q0),a8) * a8 * pow(Nes,(a8-1.0)) * etaXs_s;
		etas_s      = exp(-pow((`q*Nes*a3/Z/Q0),a4)*pow(U,a6)/pow(Y,a5) + ln(etasL));
		detas_s     = - pow(U,a6)/pow(Y,a5) * pow((`q*a3/Z/Q0),a4) * a4 * pow(Nes,(a4-1.0)) * etas_s;

		Res 	    = Vgsms - Vch - `q*Nd/Cins - `q*Nes/Cins
			- Vt*ln((`q*Nes*Nes + 2.0*(1.0-alphae_s)*`q*Nes*Nd)/coef/etas_s + Nes/(Ach*ni)*etaXs_s) - offset;

		Jaco 	    = - `q/Cins
			- Vt*((2.0*`q*Nes + 2.0*(1.0-alphae_s-dalphae_s*Nes)*`q*Nd)/coef/etas_s
			- (`q*Nes*Nes + 2.0*(1.0-alphae_s)*Nes*`q*Nd)/coef/(etas_s*etas_s)*detas_s
			+ 1/(Ach*ni)*etaXs_s + Nes/(Ach*ni)*detaXs_s) /
			((`q*Nes*Nes + 2.0*(1.0-alphae_s)*`q*Nes*Nd)/coef/etas_s + Nes/(Ach*ni)*etaXs_s);
	end

	update = - Res/Jaco;
	Nes    = Nes + update;

	end

	Qes	= -`q * Nes;   //C/m^2
	Qestd	= -`q * Nes / Pch / 1e4;   //C/cm^2
	qes	= +`q * Nes / Cins;

	if (SCEMOD == 1) begin
		Esat = 2.0 * vsat / un0;
		EsatL = Esat * Leff;
		tmp = (qes + 2.0 * Vt);
		Vdsat = EsatL * tmp / (EsatL + tmp);
		Vdseff = Vds / pow((1.0+pow((Vds/Vdsat),mexp)),inv_mexp);
		deltaL = Lambdaeff * ln( 1.0+(Vds-Vdseff)/VE );
		Leff = Leff - deltaL;
	end

	// initial solution for calculation
	Ned = Ned_i;

	// Drain side compact charge core model
	Vch = Vds - Vddi;

	for (iter = 1; iter <= 50; iter = iter + 1) begin

	if (QCEMOD == 0) begin

		alphae_d    = (alphaeL * alphaeH_s) / (alphaeL + alphaeH_s);
		dalphae_d   = -(((pow(alphaeL,2)*aa*bb*`q)/Q0)*pow(`q*Ned/Q0,(-bb-1))) / pow((alphaeL + aa*pow((`q*Ned/Q0),-bb)),2);

		Res	    = Vgsms - Vch - `q*Nd/Cins - `q*Ned/Cins - Vt*ln((`q*Ned*Ned + 2.0*(1.0-alphae_d)*`q*Ned*Nd)/coef + beta2*Ned/(Ach*ni)) - offset;
		Jaco	    = - `q/Cins - Vt*((2.0*`q*Ned + 2.0*(1.0 - alphae_d - dalphae_d*Ned)*`q*Nd)/coef + beta2/(Ach*ni))
				/ ((`q*Ned*Ned + 2.0*(1.0-alphae_d)*`q*Ned*Nd)/coef + beta2*Ned/(Ach*ni));

	end else if (QCEMOD == 1) begin

		alphae_d    = 1.0/(1.0/0.5 + pow((`q*Ned/Q0/X/Y),a2)/a1)*alphaeL/0.5;
		dalphae_d   = - 1.0/pow((1.0/0.5 + pow((`q*Ned/Q0/X/Y),a2)/a1),2) * a2/a1 * `q/(Q0*X*Y) * pow((`q*Ned/Q0/X/Y),(a2-1.0))*alphaeL/0.5 ;
		etaXs_d     = exp(ln(etaXL/etasL) + (pow((`q*Ned*a7/Z/Q0),a8))*pow(U,a10)/pow(Y,a9));
		detaXs_d    = pow(U,a10)/pow(Y,a9) * pow((`q*a7/Z/Q0),a8) * a8 * pow(Ned,(a8-1.0)) * etaXs_d;
		etas_d      = exp(-pow((`q*Ned*a3/Z/Q0),a4)*pow(U,a6)/pow(Y,a5) + ln(etasL));
		detas_d     = - pow(U,a6)/pow(Y,a5) * pow((`q*a3/Z/Q0),a4) * a4 * pow(Ned,(a4-1.0)) * etas_d;

		Res	= Vgsms - Vch - `q*Nd/Cins - `q*Ned/Cins
			- Vt*ln((`q*Ned*Ned + 2.0*(1.0-alphae_d)*`q*Ned*Nd)/(coef*etas_d) + Ned/(Ach*ni)*etaXs_d);
		Jaco	= - `q/Cins
			- Vt*((2.0*`q*Ned + 2.0*(1.0 - alphae_d - dalphae_d*Ned)*`q*Nd)/(coef*etas_d)
			- (`q*Ned*Ned + 2.0*(1.0-alphae_d)*`q*Ned*Nd)/coef/(etas_d*etas_d)*detas_d
			+ 1.0/(Ach*ni)*etaXs_d + Ned/(Ach*ni)*detaXs_d) /
			((`q*Ned*Ned + 2.0*(1.0-alphae_d)*`q*Ned*Nd)/coef/etas_d + Ned/(Ach*ni)*etaXs_d);

	end

	update = - Res / Jaco;
	Ned    = Ned + update;

	end

	Qed    = -`q * Ned; // C/m2
	Qedtd  = -`q * Ned / Pch / 1e4; // C/cm2
	qed    = +`q * Ned / Cins;

	// average charge
	qea    = 0.5 * (qes + qed);

	// current calculation
	if (QCEMOD == 0) begin // Semi classical

		Ids = `q*un0/Leff*
			(
				(
				- `q*Ned*Ned/(2*Cins) - 2*Vt*Ned
				+ Vt/`q*(2*(1.0-alphae_s)*`q*Nd + 2*Q0*beta2)*ln(`q*Ned + 2*(1.0-alphae_s)*`q*Nd + 2*Q0*beta2)
				)
				-
				(
				- `q*Nes*Nes/(2*Cins) - 2*Vt*Nes
				+ Vt/`q*(2*(1.0-alphae_s)*`q*Nd + 2*Q0*beta2)*ln(`q*Nes + 2*(1.0-alphae_s)*`q*Nd + 2*Q0*beta2)
				)
			);

	end else if (QCEMOD == 1) begin  // Quantum confinement effect

		Ids = `q*un0/Leff*
			(
				(
				- `q*Ned*Ned/(2*Cins)
				- 2.0*Vt*Ned - Vt*Ned*ln(`q*Ned + 2.0*(1.0-alphae_s)*`q*Nd + 2.0*Q0*etaXs_d*etas_d)
				+ Vt/`q*(`q*Ned + 2*(1.0-alphae_s)*`q*Nd + 2*Q0*etaXL)*ln(`q*Ned + 2.0*(1.0 - alphae_s)*`q*Nd + 2.0*Q0*etaXL)
				+ (Vt*Ned - (Vt*Z*Q0)/(`q * (1.0+a4) * a3))*pow((a3/Z*`q*Ned/Q0),a4)*pow(U,a6)/pow(Y,a5)
				)
				-
				(
				- `q*Nes*Nes/(2.0*Cins)
				- 2.0*Vt*Nes - Vt*Nes*ln(`q*Nes + 2.0*(1.0-alphae_s)*`q*Nd + 2.0*Q0*etaXs_s*etas_s)
				+ Vt/`q*(`q*Nes + 2.0*(1.0-alphae_s)*`q*Nd + 2*Q0*etaXL)*ln(`q*Nes + 2.0*(1.0 - alphae_s)*`q*Nd + 2.0*Q0*etaXL)
				+ (Vt*Nes - (Vt*Z*Q0)/(`q * (1.0+a4) * a3))*pow((a3/Z*`q*Nes/Q0),a4)*pow(U,a6)/pow(Y,a5)
				)
			);
	end

	IDS   = Ids;
	I(di,si) <+ IDS;

	$display("\n");
	$display("Z0 %f ZL %f", Z0, ZL);
	//$display("Vch %f", Vch);
	$display("Vgs %f dVgs %e", Vgs, dVgs);
	$display("deltaL %e", deltaL);
	$display("Lambda %e Lambdaeff %e", Lambda, Lambdaeff);
  	$display("Vdsat %f Vdseff %f", Vdsat, Vdseff);
	$display("S Vgs %0.2f Nes %e", Vgs, Nes);
	$display("D Vgs %0.2f Ned %e", Vgs, Ned);

	end

endmodule
